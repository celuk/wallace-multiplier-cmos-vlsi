procedure( _switch1paramCheck()
 cond(
        (artStringToInt(cdfgData->acPosition_str->value) && (nequal cdfgData->acPosition_str->value "0") && (nequal cdfgData->acPosition_str->value "1")
     artWarn("Invalid value of ac position paramter given, setting to default value 0")
     cdfgData->acPosition_str->value="0")
        (artStringToInt(cdfgData->dcPosition_str->value) && (nequal cdfgData->dcPosition_str->value "0") && (nequal cdfgData->dcPosition_str->value "1")
     artWarn("Invalid value of dc position paramter given, setting to default value 0")
     cdfgData->dcPosition_str->value="0")
       (artStringToInt(cdfgData->icPosition_str->value) && (nequal cdfgData->icPosition_str->value "0") && (nequal cdfgData->icPosition_str->value "1")
     artWarn("Invalid value of ic position paramter given, setting to default value 0")
     cdfgData->icPosition_str->value="0")
      (artStringToInt(cdfgData->tranPosition_str->value) && (nequal cdfgData->tranPosition_str->value "0") && (nequal cdfgData->tranPosition_str->value "1")
     artWarn("Invalid value of tran position paramter given, setting to default value 0")
     cdfgData->tranPosition_str->value="0")
      (artStringToInt(cdfgData->position_str->value) && (nequal cdfgData->position_str->value "0") && (nequal cdfgData->position_str->value "1")
     artWarn("Invalid value of position paramter given, setting to default value 0")
     cdfgData->position_str->value="0")
        )
 )

procedure( _switch2paramCheck()
 cond(
        (artStringToInt(cdfgData->acPosition_str->value) && (nequal cdfgData->acPosition_str->value "0") && (nequal cdfgData->acPosition_str->value "1") && (nequal cdfgData->acPosition_str->value "2")
     artWarn("Invalid value of ac position paramter given, setting to default value 0")
     cdfgData->acPosition_str->value="0")
        (artStringToInt(cdfgData->dcPosition_str->value) && (nequal cdfgData->dcPosition_str->value "0") && (nequal cdfgData->dcPosition_str->value "1") && (nequal cdfgData->dcPosition_str->value "2")
     artWarn("Invalid value of dc position paramter given, setting to default value 0")
     cdfgData->dcPosition_str->value="0")
       (artStringToInt(cdfgData->icPosition_str->value) && (nequal cdfgData->icPosition_str->value "0") && (nequal cdfgData->icPosition_str->value "1") && (nequal cdfgData->icPosition_str->value "2")
     artWarn("Invalid value of ic position paramter given, setting to default value 0")
     cdfgData->icPosition_str->value="0")
      (artStringToInt(cdfgData->tranPosition_str->value) && (nequal cdfgData->tranPosition_str->value "0") && (nequal cdfgData->tranPosition_str->value "1") && (nequal cdfgData->tranPosition_str->value "2")
     artWarn("Invalid value of tran position paramter given, setting to default value 0")
     cdfgData->tranPosition_str->value="0")
      (artStringToInt(cdfgData->position_str->value) && (nequal cdfgData->position_str->value "0") && (nequal cdfgData->position_str->value "1") && (nequal cdfgData->position_str->value "2")
     artWarn("Invalid value of position paramter given, setting to default value 0")
     cdfgData->position_str->value="0")
        )
 )

procedure( _switch3paramCheck()
 cond(
        (artStringToInt(cdfgData->acPosition_str->value) && (nequal cdfgData->acPosition_str->value "0") && (nequal cdfgData->acPosition_str->value "1") && (nequal cdfgData->acPosition_str->value "2") && (nequal cdfgData->acPosition_str->value "3")
     artWarn("Invalid value of ac position paramter given, setting to default value 0")
     cdfgData->acPosition_str->value="0")
        (artStringToInt(cdfgData->dcPosition_str->value) && (nequal cdfgData->dcPosition_str->value "0") && (nequal cdfgData->dcPosition_str->value "1") && (nequal cdfgData->dcPosition_str->value "2") && (nequal cdfgData->dcPosition_str->value "3")
     artWarn("Invalid value of dc position paramter given, setting to default value 0")
     cdfgData->dcPosition_str->value="0")
       (artStringToInt(cdfgData->icPosition_str->value) && (nequal cdfgData->icPosition_str->value "0") && (nequal cdfgData->icPosition_str->value "1") && (nequal cdfgData->icPosition_str->value "2") && (nequal cdfgData->icPosition_str->value "3")
     artWarn("Invalid value of ic position paramter given, setting to default value 0")
     cdfgData->icPosition_str->value="0")
      (artStringToInt(cdfgData->tranPosition_str->value) && (nequal cdfgData->tranPosition_str->value "0") && (nequal cdfgData->tranPosition_str->value "1") && (nequal cdfgData->tranPosition_str->value "2") && (nequal cdfgData->tranPosition_str->value "3")
     artWarn("Invalid value of tran position paramter given, setting to default value 0")
     cdfgData->tranPosition_str->value="0")
      (artStringToInt(cdfgData->position_str->value) && (nequal cdfgData->position_str->value "0") && (nequal cdfgData->position_str->value "1") && (nequal cdfgData->position_str->value "2") && (nequal cdfgData->position_str->value "3")
     artWarn("Invalid value of position paramter given, setting to default value 0")
     cdfgData->position_str->value="0")
        )
 )

procedure( _switch4paramCheck()
 cond(
        (artStringToInt(cdfgData->acPosition_str->value) && (nequal cdfgData->acPosition_str->value "0") && (nequal cdfgData->acPosition_str->value "1") && (nequal cdfgData->acPosition_str->value "2") && (nequal cdfgData->acPosition_str->value "3") && (nequal cdfgData->acPosition_str->value "4")
     artWarn("Invalid value of ac position paramter given, setting to default value 0")
     cdfgData->acPosition_str->value="0")
        (artStringToInt(cdfgData->dcPosition_str->value) && (nequal cdfgData->dcPosition_str->value "0") && (nequal cdfgData->dcPosition_str->value "1") && (nequal cdfgData->dcPosition_str->value "2") && (nequal cdfgData->dcPosition_str->value "3") && (nequal cdfgData->dcPosition_str->value "4")
     artWarn("Invalid value of dc position paramter given, setting to default value 0")
     cdfgData->dcPosition_str->value="0")
       (artStringToInt(cdfgData->icPosition_str->value) && (nequal cdfgData->icPosition_str->value "0") && (nequal cdfgData->icPosition_str->value "1") && (nequal cdfgData->icPosition_str->value "2") && (nequal cdfgData->icPosition_str->value "3") && (nequal cdfgData->icPosition_str->value "4")
     artWarn("Invalid value of ic position paramter given, setting to default value 0")
     cdfgData->icPosition_str->value="0")
      (artStringToInt(cdfgData->tranPosition_str->value) && (nequal cdfgData->tranPosition_str->value "0") && (nequal cdfgData->tranPosition_str->value "1") && (nequal cdfgData->tranPosition_str->value "2") && (nequal cdfgData->tranPosition_str->value "3") && (nequal cdfgData->tranPosition_str->value "4")
     artWarn("Invalid value of tran position paramter given, setting to default value 0")
     cdfgData->tranPosition_str->value="0")
      (artStringToInt(cdfgData->position_str->value) && (nequal cdfgData->position_str->value "0") && (nequal cdfgData->position_str->value "1") && (nequal cdfgData->position_str->value "2") && (nequal cdfgData->position_str->value "3") && (nequal cdfgData->position_str->value "4")
     artWarn("Invalid value of position paramter given, setting to default value 0")
     cdfgData->position_str->value="0")
        )
 )
